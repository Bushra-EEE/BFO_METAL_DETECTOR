* C:\Users\user\Downloads\Telegram Desktop\poweramplifier.sch

* Schematics Version 9.2
* Sun Sep 27 01:24:52 2026

** Analysis setup **
.tran 1u 3m 0 10u
.OP

* From [PSPICE NETLIST] section of d:\PSpice\PSpice.ini:
.lib "nom.lib"

.INC "poweramplifier.net"

.PROBE V(*) I(*) W(*) D(*) NOISE(*)

.END
